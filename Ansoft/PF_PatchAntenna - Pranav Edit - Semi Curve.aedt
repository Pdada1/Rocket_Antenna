# Ansys Electronics Desktop project, version 2024.2
project variables:
  $Patch_Length = 40mm
  $Patch_Width = 98.8mm  # optimise 49.4mm..148.2mm
  $Substrate_Length = 130mm  # optimise 65mm..195mm
  $Substrate_Width = 130mm  # optimise 65mm..195mm
  $Air_Height = 0.08meter
  $X_Offset = 0mm  # optimise 2mm..6mm
  $Patch_Radius_RH = 7.07mm  # optimise 7mm..21mm
  $Patch_Height_B = 2.373499mm  # optimise 2.35mm..7.05mm
materials:
  vacuum: permittivity=1
  Rogers RT/duroid 5880 (tm): permittivity=2.2 dielectric_loss_tangent=0.0009
  polyethylene: permittivity=2.25 dielectric_loss_tangent=0.001
  pec: conductivity=1e+30
  air: permittivity=1.0006 permeability=1.0000004
  Rogers TMM 4 (tm): permittivity=4.5 dielectric_loss_tangent=0.002
  FR4_epoxy: permittivity=4.4 dielectric_loss_tangent=0.02
  PLA: permittivity=2.54 dielectric_loss_tangent=0.015

design HFSSDesign1 (HFSS, HFSS Terminal Network, model units cm)
geometry:
  Sub1 [FR4_epoxy] = box(corner=(-($Substrate_Length/2), -($Substrate_Width/2), 0cm), size=($Substrate_Length, $Substrate_Width, $Substrate_Thickness))
  Inf_GND [Rogers RT/duroid 5880 (tm)] = object_from(Sub1.face(-z))
  Cutout = circle(normal=Z, centre=((-$X_Offset), 0cm, 0cm), radius=0.16cm)
  Inf_GND.subtract(Cutout)
  Coax [polyethylene] = cylinder(axis=Z, base_centre=(-$X_Offset, 0cm, 0cm), radius=0.16cm, height=-0.5cm)
  CoaxPin [pec] = cylinder(axis=Z, base_centre=(-$X_Offset, 0cm, 0cm), radius=0.07cm, height=-0.5cm)
  Proble [pec] = cylinder(axis=Z, base_centre=((-$X_Offset), 0cm, 0cm), radius=0.07cm, height=$Substrate_Thickness+sqrt($Patch_Radius_RH^2-($X_Offset^2))+$Patch_Height_B-$Patch_Radius_RH)
  Air [air] = box(corner=(-0.075, -0.075, 0cm), size=(0.15, 0.15, $Air_Height))
  Patch_Curve [FR4_epoxy] = cylinder(axis=Y, base_centre=(0cm, -$Patch_Width/2, -$Patch_Radius_RH+$Patch_Height_B+$Substrate_Thickness), radius=$Patch_Radius_RH, height=$Patch_Width)
  Patch_Curve.split(plane=XY, keep=PositiveOnly)
  Proble_For_Cut = cylinder(axis=Z, base_centre=((-$X_Offset), 0cm, 0cm), radius=0.07cm, height=$Substrate_Thickness+sqrt($Patch_Radius_RH^2-($X_Offset^2))+$Patch_Height_B-$Patch_Radius_RH)
  Patch_Curve.subtract(Proble_For_Cut)
  Proble_For_Cut_1 = cylinder(axis=Z, base_centre=((-$X_Offset), 0cm, 0cm), radius=0.07cm, height=$Substrate_Thickness+sqrt($Patch_Radius_RH^2-($X_Offset^2))+$Patch_Height_B-$Patch_Radius_RH)
  Sub1.subtract(Proble_For_Cut_1)
  Patch_Curve1 = cylinder(axis=Y, base_centre=(0cm, -$Patch_Width/2, -$Patch_Radius_RH+$Patch_Height_B+$Substrate_Thickness), radius=$Patch_Radius_RH, height=$Patch_Width)
  Patch_Curve1.split(plane=XY, keep=PositiveOnly)
  Proble_For_Cut1 = cylinder(axis=Z, base_centre=((-$X_Offset), 0cm, 0cm), radius=0.07cm, height=$Substrate_Thickness+sqrt($Patch_Radius_RH^2-($X_Offset^2))+$Patch_Height_B-$Patch_Radius_RH)
  Patch_Curve1.subtract(Proble_For_Cut1)
  Sub1.subtract(Patch_Curve1)
  Patch [FR4_epoxy] = object_from(Patch_Curve.face(side))
boundaries and excitations:
  PerfE1: Perfect E Objects=Inf_GND InfGroundPlane
  Rad1: Radiation Faces=Air.face(+z, -y, -x, +y, +x)
  PerfE2: Perfect E Objects=Patch
  CoaxPin_T1: Terminal port=P1 Faces=CoaxPin.face(-z end) TerminalResistance=50ohm
  P1: Wave Port Faces=Coax.face(-z end) WavePortType=Terminal NumModes=1
setups:
  Setup1: HfssDriven Frequency=915MHz MaxDeltaS=0.02 MaximumPasses=20 MinimumPasses=1 MinimumConvergedPasses=1 PercentRefinement=30 BasisOrder=1 PortAccuracy=2 DrivenSolverType="Direct Solver" VariablesForDerivatives($Patch_Height_B, $Patch_Length, $Patch_Radius_RH, $Patch_Width, $Substrate_Length, $Substrate_Width, $X_Offset) VariableFlagsForDerivatives(1, 1, 1, 1, 1, 1, 1)
    sweep Sweep: 600MHz to 1.3GHz, 350 points; Type=Interpolating InterpTolerance=0.5 InterpMaxSolns=250 PassivityErrorTolerance=0.0001
    sweep Test_Sweep: 11GHz to 13GHz, 401 points; disabled Type=Interpolating InterpTolerance=0.5 InterpMaxSolns=250 PassivityErrorTolerance=0.0001
    sweep Long_Sweep: 100MHz to 40GHz, 601 points; disabled Type=Interpolating InterpTolerance=0.5 InterpMaxSolns=250 PassivityErrorTolerance=0.0001
source amplitudes:
  P1:1: 1 0deg
radiation setups:
  ff_2d: Infinite Sphere Theta=-180deg..180deg step 2deg Phi=0deg..90deg step 90deg
reports:
  Terminal S Parameter Plot 1: dB(St(CoaxPin_T1,CoaxPin_T1)) vs Freq on Setup1 : Sweep; markers m1 at 0.96303725GHz, m2 at 0.94297994GHz, MX1 at x=9.15e+08, MY1 at y=-15
  Terminal S Parameter Chart 1: St(CoaxPin_T1,CoaxPin_T1) on Setup1 : Sweep [Freq=all]; markers m1 at 915MHz
  Plot 1:
  Terminal S Parameter Plot 2: dB(St(CoaxPin_T1,CoaxPin_T1)) vs Freq on Setup1 : Test_Sweep [$Patch_Length=all]
  Terminal S Parameter Plot 3: dB(St(CoaxPin_T1,CoaxPin_T1)) vs Freq on Setup1 : Long_Sweep [$Patch_Length=all]; markers m2 at 5.6275GHz
  Terminal S Parameter Plot 4: dB(St(CoaxPin_T1,CoaxPin_T1)) vs Freq on Setup1 : Long_Sweep [$Patch_Length=all]
  Tune Terminal S Parameter Plot 2: dB(TuneSt(CoaxPin_T1,CoaxPin_T1,All)) vs Freq on Setup1 : Long_Sweep [$Patch_Length=all]; markers MX1 at x=9.15e+08
  Terminal S Parameter Plot 5: dB(St(CoaxPin_T1,CoaxPin_T1)) vs Freq on Setup1 : Sweep [$Patch_Length=all $Patch_Width=all $X_Offset=all $Patch_Radius_RH=all $Patch_Height_B=all]

# Ansys Electronics Desktop project, version 2024.2
project variables:
  $Substrate_Length = 130mm
  $Substrate_Width = 130mm
  $Substrate_Thickness = 2mm
  $X_Offset = 0mm
  $Coax_Radius = 1.395mm
  $Radius_H = 60mm
  $Patch_Width = 4680mil
  $Height_B = 20mm
  $Coax_Height = -0.5cm
  $Probe_Radius = 0.24mm
materials:
  vacuum: permittivity=1
  FR4_epoxy: permittivity=4.4 dielectric_loss_tangent=0.02
  polyethylene: permittivity=2.25 dielectric_loss_tangent=0.001
  copper: permeability=0.999991 conductivity=58000000
  pec: conductivity=1e+30
  air: permittivity=1.0006 permeability=1.0000004
  PLA_(Added): permittivity=2.54 dielectric_loss_tangent=0.015
  quartz_glass: permittivity=3.78
  Rogers RO3003 (tm): permittivity=3 dielectric_loss_tangent=0.0013
  Radix 3D Print: permittivity=2.8 dielectric_loss_tangent=0.0043

design HFSSDesign1 (HFSS, HFSS Terminal Network, model units mm)
geometry:
  Sub1 [Radix 3D Print] = box(corner=(-($Substrate_Length/2), -($Substrate_Width/2), 0mm), size=($Substrate_Length, $Substrate_Width, -$Substrate_Thickness))
  Inf_GND [FR4_epoxy] = object_from(Sub1.face(-z))
  Cutout = circle(normal=Z, centre=($X_Offset, 0mm, -$Substrate_Thickness), radius=$Coax_Radius)
  Inf_GND.subtract(Cutout)
  Curve [Radix 3D Print] = cylinder(axis=Y, base_centre=(0mm, -$Patch_Width/2, -$Radius_H+$Height_B), radius=$Radius_H, height=$Patch_Width)
  Curve.split(plane=XY, keep=PositiveOnly)
  Patch [FR4_epoxy] = object_from(Curve.face(side))
  Box1 [air] = box(corner=(-6.5cm, -6.5cm, -$Substrate_Thickness+$Coax_Height), size=(13cm, 13cm, 20cm))
  Coax_Cover [polyethylene] = cylinder(axis=Z, base_centre=($X_Offset, 0mm, -$Substrate_Thickness), radius=$Coax_Radius, height=-5mm)
  Cylinder1 [copper] = cylinder(axis=Z, base_centre=($X_Offset, 0mm, -$Substrate_Thickness), radius=$Probe_Radius, height=-5mm)
  Cylinder2 [copper] = cylinder(axis=Z, base_centre=($X_Offset, 0mm, -$Substrate_Thickness), radius=$Probe_Radius, height=$Height_B+$Substrate_Thickness+sqrt(sqr($Radius_H)-sqr($X_Offset))-$Radius_H)
  Cylinder2_1 = Cylinder2.copy()
  Sub1.subtract(Cylinder2_1)
  Cylinder2_2 = Cylinder2.copy()
  Curve.subtract(Cylinder2_2)
boundaries and excitations:
  Rad1: Radiation Faces=Box1.face(+z, -y, -x, +y, +x)
  PerfE3: Perfect E Objects=Inf_GND InfGroundPlane
  PerfE4: Perfect E Objects=Patch
  Cylinder1_T1: Terminal port=1 Faces=Cylinder1.face(-z end) TerminalResistance=50ohm
  1: Wave Port Faces=Coax_Cover.face(-z end) WavePortType=Terminal NumModes=1
mesh:
  initial mesh: GlobalSurfApproximation{CurvedSurfaceApproxChoice=UseSlider SliderMeshSettings=6}
setups:
  Setup1: HfssDriven Frequency=0.915GHz MaxDeltaS=0.02 MaximumPasses=20 MinimumPasses=1 MinimumConvergedPasses=1 PercentRefinement=30 BasisOrder=1 PortAccuracy=2 DrivenSolverType="Direct Solver" VariablesForDerivatives($Height_B, $Patch_Width, $Radius_H, $X_Offset) VariableFlagsForDerivatives(1, 1, 1, 1)
    sweep Sweep: 200MHz to 3GHz, 401 points; Type=Interpolating InterpTolerance=0.5 InterpMaxSolns=250 PassivityErrorTolerance=0.0001
source amplitudes:
  1:1: 1V 0deg
optimetrics:
  ParametricSetup1: Parametric Sim._Setups=[Setup1]
    sweep $Radius_H: LIN 55mm 65mm 1mm
    sweep $Height_B: LIN 0mm 60mm 5mm
radiation setups:
  Infinite Sphere1: Infinite Sphere Theta=0deg..180deg step 2deg Phi=-180deg..180deg step 2deg
reports:
  Tune Terminal S Parameter Plot 1: dB(TuneSt(Cylinder1_T1,Cylinder1_T1,All)) vs Freq on Setup1 : Sweep [$Radius_H=all $Height_B=all]; markers MX1 at x=9.15e+08, MX2 at x=1.52964e+09
  Gain Plot 1: GainPhi vs Phi, Theta on Setup1 : LastAdaptive, Infinite Sphere1 [Freq=0.915GHz $Radius_H=30mm $Height_B=5mm]
  Terminal S Parameter Chart 1: St(Cylinder1_T1,Cylinder1_T1) on Setup1 : Sweep [Freq=all $Radius_H=all $Height_B=all]
  Terminal Z Parameter Chart 1: Zt(Cylinder1_T1,Cylinder1_T1) on Setup1 : Sweep [Freq=all $Radius_H=all $Height_B=all]

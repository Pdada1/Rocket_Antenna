# Ansys Electronics Desktop project, version 2024.2
project variables:
  $Substrate_Width = 0.11246602meter
  $Substrate_Thickness = 0.006meter
  $Substrate_Length = 0.109494912meter
materials:
  vacuum: permittivity=1
  Rogers TMM 4 (tm): permittivity=4.5 dielectric_loss_tangent=0.002

design HFSSDesign1 (HFSS, Characteristic Mode, model units mm)
geometry:
  Sub1 [Rogers TMM 4 (tm)] = box(corner=(-($Substrate_Length/2), -($Substrate_Width/2), 0cm), size=($Substrate_Length, $Substrate_Width, $Substrate_Thickness))
setups:
  Setup2: HfssCMA ModalSignificance=0.02 MaxDeltaE=0.02 AdaptiveFreq=915MHz MaximumPasses=20 MinimumPasses=1 MinimumConvergedPasses=1 PercentRefinement=30 BasisOrder=0
    sweep Sweep: 300MHz to 1.5GHz step 50MHz; Type=Discrete
source amplitudes:
  #-10:1: 1 0deg
  #-10:2..#-10:10: 0 0deg

# Ansys Electronics Desktop project, version 2024.2
materials:
  vacuum: permittivity=1
  FR4_epoxy: permittivity=4.4 dielectric_loss_tangent=0.02
  PMLGroup1_Z_1: permittivity{anisotropic component1=1.1 component2=1.1 component3=0.45454545} permeability{anisotropic component1=1.1 component2=1.1 component3=0.45454545} dielectric_loss_tangent{anisotropic component1=1 component2=1 component3=-1} magnetic_loss_tangent{anisotropic component1=1 component2=1 component3=-1}
  PMLGroup1_XZ_1: permittivity{anisotropic component1=1 component2=0.01 component3=1} permeability{anisotropic component1=1 component2=0.01 component3=1} dielectric_loss_tangent{anisotropic component1=0 component2=242 component3=0} magnetic_loss_tangent{anisotropic component1=0 component2=242 component3=0}
  PMLGroup1_YZ_1: permittivity{anisotropic component1=0.01 component2=1 component3=1} permeability{anisotropic component1=0.01 component2=1 component3=1} dielectric_loss_tangent{anisotropic component1=242 component2=0 component3=0} magnetic_loss_tangent{anisotropic component1=242 component2=0 component3=0}
  PMLGroup1_XYZ_1: permittivity{anisotropic component1=1.1 component2=1.1 component3=1.1} permeability{anisotropic component1=1.1 component2=1.1 component3=1.1} dielectric_loss_tangent{anisotropic component1=1 component2=1 component3=1} magnetic_loss_tangent{anisotropic component1=1 component2=1 component3=1}

design Bowtie_ATK (HFSS, HFSS Terminal Network, model units cm)
options: Allow_Material_Override Save_Adaptive_support_files open_region{BoundaryType=2 OpFreq=0.915GHz}
variables:
  # --Antenna Dimensions
  Inner_Width = 0.23cm
  Outer_Width = 4.1cm
  Arm_Length = 4.56cm
  Port_Gap_Width = 0.23cm
  # --Substrate Dimensions
  subH = 0.1575cm
  subX = 18cm
  subY = 18cm
geometry:
  sub [FR4_epoxy] = box(corner=(-subX/2, -subY/2, 0cm), size=(subX, subY, -subH))
  NewObject_59AZ2I = polyline((-Inner_Width/2.0, Port_Gap_Width/2.0, 0) (Inner_Width/2.0, Port_Gap_Width/2.0, 0cm))
  arm = polyline((-Outer_Width/2.0, Port_Gap_Width/2.0+Arm_Length, 0cm) (Outer_Width/2.0, Port_Gap_Width/2.0+Arm_Length, 0cm))
  arm.connect(NewObject_59AZ2I)
  arm1 = arm.duplicate_around_axis(axis=Z, angle=180deg, total=2)
  port1 = rectangle(corner=(-Inner_Width/2, -Port_Gap_Width/2, 0cm), x_size=Inner_Width, y_size=Port_Gap_Width)
  RadiatingSurface [vacuum] = region(absolute_offset=8.1967213cm on all sides)
  coordinate_system FaceCS1 = face of RadiatingSurface: Origin=(17.196721, -17.196721, 8.1967213) FaceID=RadiatingSurface.face(+z) AxisPosn=(17.196721, 17.196721, 8.1967213) WhichAxis=X ZRotationAngle=0deg XOffset=0cm YOffset=0cm FaceNormal(0, 0, 1)
  PML_RadiatingSurface_1 [PMLGroup2_Z_1, oriented by FaceCS1] = sweep_along_normal(RadiatingSurface.face(+z), length=13.685185cm)
  coordinate_system FaceCS2 = face of RadiatingSurface: Origin=(17.196721, -17.196721, -8.3542213) FaceID=RadiatingSurface.face(-z) AxisPosn=(-17.196721, -17.196721, -8.3542213) WhichAxis=X ZRotationAngle=0deg XOffset=0cm YOffset=0cm FaceNormal(0, 0, -1)
  PML_RadiatingSurface_2 [PMLGroup2_Z_1, oriented by FaceCS2] = sweep_along_normal(RadiatingSurface.face(-z), length=13.685185cm)
  coordinate_system FaceCS3 = face of RadiatingSurface: Origin=(17.196721, -17.196721, 8.1967213) FaceID=RadiatingSurface.face(-y) AxisPosn=(-17.196721, -17.196721, 8.1967213) WhichAxis=X ZRotationAngle=0deg XOffset=0cm YOffset=0cm FaceNormal(0, -1, 0)
  PML_RadiatingSurface_3 [PMLGroup2_Z_1, oriented by FaceCS3] = sweep_along_normal(RadiatingSurface.face(-y), length=13.685185cm)
  coordinate_system FaceCS4 = face of RadiatingSurface: Origin=(-17.196721, -17.196721, 8.1967213) FaceID=RadiatingSurface.face(-x) AxisPosn=(-17.196721, 17.196721, 8.1967213) WhichAxis=X ZRotationAngle=0deg XOffset=0cm YOffset=0cm FaceNormal(-1, 0, 0)
  PML_RadiatingSurface_4 [PMLGroup2_Z_1, oriented by FaceCS4] = sweep_along_normal(RadiatingSurface.face(-x), length=13.685185cm)
  coordinate_system FaceCS5 = face of RadiatingSurface: Origin=(-17.196721, 17.196721, 8.1967213) FaceID=RadiatingSurface.face(+y) AxisPosn=(17.196721, 17.196721, 8.1967213) WhichAxis=X ZRotationAngle=0deg XOffset=0cm YOffset=0cm FaceNormal(0, 1, 0)
  PML_RadiatingSurface_5 [PMLGroup2_Z_1, oriented by FaceCS5] = sweep_along_normal(RadiatingSurface.face(+y), length=13.685185cm)
  coordinate_system FaceCS6 = face of RadiatingSurface: Origin=(17.196721, 17.196721, -8.3542213) FaceID=RadiatingSurface.face(+x) AxisPosn=(17.196721, 17.196721, 8.1967213) WhichAxis=X ZRotationAngle=0deg XOffset=0cm YOffset=0cm FaceNormal(1, 0, 0)
  PML_RadiatingSurface_6 [PMLGroup2_Z_1, oriented by FaceCS6] = sweep_along_normal(RadiatingSurface.face(+x), length=13.685185cm)
  PML_RadiatingSurface_7 [PMLGroup2_XZ_1, oriented by FaceCS1] = sweep_along_normal(PML_RadiatingSurface_1.face(at (0, -17.1967, 15.0393)), length=13.685185cm)
  PML_RadiatingSurface_8 [PMLGroup2_YZ_1, oriented by FaceCS4] = sweep_along_normal(PML_RadiatingSurface_1.face(at (-17.1967, 0, 15.0393)), length=13.685185cm)
  PML_RadiatingSurface_9 [PMLGroup2_YZ_1, oriented by FaceCS5] = sweep_along_normal(PML_RadiatingSurface_1.face(at (0, 17.1967, 15.0393)), length=13.685185cm)
  PML_RadiatingSurface_10 [PMLGroup2_YZ_1, oriented by FaceCS1] = sweep_along_normal(PML_RadiatingSurface_1.face(at (17.1967, 0, 15.0393)), length=13.685185cm)
  PML_RadiatingSurface_11 [PMLGroup2_YZ_1, oriented by FaceCS2] = sweep_along_normal(PML_RadiatingSurface_2.face(at (0, -17.1967, -15.1968)), length=13.685185cm)
  coordinate_system FaceCS7 = face of RadiatingSurface: Origin=(-17.196721, -17.196721, -8.3542213) FaceID=RadiatingSurface.face(-z) AxisPosn=(-17.196721, 17.196721, -8.3542213) WhichAxis=X ZRotationAngle=0deg XOffset=0cm YOffset=0cm FaceNormal(0, 0, -1)
  PML_RadiatingSurface_12 [PMLGroup2_YZ_1, oriented by FaceCS7] = sweep_along_normal(PML_RadiatingSurface_2.face(at (-17.1967, 0, -15.1968)), length=13.685185cm)
  coordinate_system FaceCS8 = face of RadiatingSurface: Origin=(-17.196721, 17.196721, -8.3542213) FaceID=RadiatingSurface.face(-z) AxisPosn=(17.196721, 17.196721, -8.3542213) WhichAxis=X ZRotationAngle=0deg XOffset=0cm YOffset=0cm FaceNormal(0, 0, -1)
  PML_RadiatingSurface_13 [PMLGroup2_YZ_1, oriented by FaceCS8] = sweep_along_normal(PML_RadiatingSurface_2.face(at (0, 17.1967, -15.1968)), length=13.685185cm)
  PML_RadiatingSurface_14 [PMLGroup2_XZ_1, oriented by FaceCS2] = sweep_along_normal(PML_RadiatingSurface_2.face(at (17.1967, 0, -15.1968)), length=13.685185cm)
  PML_RadiatingSurface_15 [PMLGroup2_XZ_1, oriented by FaceCS4] = sweep_along_normal(PML_RadiatingSurface_3.face(at (-17.1967, -24.0393, -0.07875)), length=13.685185cm)
  PML_RadiatingSurface_16 [PMLGroup2_XZ_1, oriented by FaceCS3] = sweep_along_normal(PML_RadiatingSurface_3.face(at (17.1967, -24.0393, -0.07875)), length=13.685185cm)
  PML_RadiatingSurface_17 [PMLGroup2_XZ_1, oriented by FaceCS5] = sweep_along_normal(PML_RadiatingSurface_4.face(at (-24.0393, 17.1967, -0.07875)), length=13.685185cm)
  PML_RadiatingSurface_18 [PMLGroup2_YZ_1, oriented by FaceCS6] = sweep_along_normal(PML_RadiatingSurface_5.face(at (17.1967, 24.0393, -0.07875)), length=13.685185cm)
  PML_RadiatingSurface_19 [PMLGroup2_XYZ_1, oriented by FaceCS4] = sweep_along_normal(PML_RadiatingSurface_7.face(at (-17.1967, -24.0393, 15.0393)), length=13.685185cm)
  PML_RadiatingSurface_20 [PMLGroup2_XYZ_1, oriented by FaceCS1] = sweep_along_normal(PML_RadiatingSurface_7.face(at (17.1967, -24.0393, 15.0393)), length=13.685185cm)
  PML_RadiatingSurface_21 [PMLGroup2_XYZ_1, oriented by FaceCS5] = sweep_along_normal(PML_RadiatingSurface_8.face(at (-24.0393, 17.1967, 15.0393)), length=13.685185cm)
  coordinate_system FaceCS9 = face of RadiatingSurface: Origin=(17.196721, 17.196721, 8.1967213) FaceID=RadiatingSurface.face(+z) AxisPosn=(-17.196721, 17.196721, 8.1967213) WhichAxis=X ZRotationAngle=0deg XOffset=0cm YOffset=0cm FaceNormal(0, 0, 1)
  PML_RadiatingSurface_22 [PMLGroup2_XYZ_1, oriented by FaceCS9] = sweep_along_normal(PML_RadiatingSurface_9.face(at (17.1967, 24.0393, 15.0393)), length=13.685185cm)
  PML_RadiatingSurface_23 [PMLGroup2_XYZ_1, oriented by FaceCS7] = sweep_along_normal(PML_RadiatingSurface_11.face(at (-17.1967, -24.0393, -15.1968)), length=13.685185cm)
  PML_RadiatingSurface_24 [PMLGroup2_XYZ_1, oriented by FaceCS2] = sweep_along_normal(PML_RadiatingSurface_11.face(at (17.1967, -24.0393, -15.1968)), length=13.685185cm)
  PML_RadiatingSurface_25 [PMLGroup2_XYZ_1, oriented by FaceCS8] = sweep_along_normal(PML_RadiatingSurface_12.face(at (-24.0393, 17.1967, -15.1968)), length=13.685185cm)
  PML_RadiatingSurface_26 [PMLGroup2_XYZ_1, oriented by FaceCS6] = sweep_along_normal(PML_RadiatingSurface_13.face(at (17.1967, 24.0393, -15.1968)), length=13.685185cm)
boundaries and excitations:
  antennaMetal: Perfect E Objects=[arm, arm1]
  PML_radiation1: Radiation Faces=RadiatingSurface.face(+z) IsForPML
  PML_radiation2: Radiation Faces=RadiatingSurface.face(-z) IsForPML
  PML_radiation3: Radiation Faces=RadiatingSurface.face(-y) IsForPML
  PML_radiation4: Radiation Faces=RadiatingSurface.face(-x) IsForPML
  PML_radiation5: Radiation Faces=RadiatingSurface.face(+y) IsForPML
  PML_radiation6: Radiation Faces=RadiatingSurface.face(+x) IsForPML
  arm_T1: Terminal port=1 Edges=arm.edge(at (0, 0.115, 0)) TerminalResistance=50ohm
  1: Lumped Port Faces=port1.face LumpedPortType=Terminal Impedance=50ohm
  reference conductors: arm1
setups:
  ATK_Solution: HfssDriven Frequency=0.915GHz MaxDeltaS=0.02 MaximumPasses=15 MinimumPasses=1 MinimumConvergedPasses=1 PercentRefinement=30 BasisOrder=1 PortAccuracy=2 DrivenSolverType="Direct Solver" IESolverType=ACA
    sweep FF_Sweep: 0.4575GHz to 1.3725GHz, 100 points; Type=Discrete SaveFields
    sweep SParam_Sweep: 0.4575GHz to 1.3725GHz, 100 points; Type=Interpolating InterpTolerance=0.5 InterpMaxSolns=250 PassivityErrorTolerance=0.0001
source amplitudes:
  1:1: 1V 0deg
radiation setups:
  3D: Infinite Sphere Theta=0deg..180deg step 2deg Phi=-180deg..180deg step 2deg
  Elevation: Infinite Sphere Theta=-180deg..180deg step 1deg Phi=0deg..90deg step 90deg
  Azimuth: Infinite Sphere Theta=90deg..90deg step 0deg Phi=-180deg..180deg step 1deg
  ATK_2D: Infinite Sphere Theta=-180deg..180deg step 1deg Phi=0deg..90deg step 90deg
  ATK_3D: Infinite Sphere Theta=-180deg..180deg step 2deg Phi=0deg..180deg step 5deg
reports:
  ff_3D_GainTotal: dB(GainTotal) vs Phi, Theta on ATK_Solution : LastAdaptive, ATK_3D [Freq=9.15e+08]
  ff_2D_GainTotal: dB(GainTotal) vs Theta on ATK_Solution : LastAdaptive, ATK_2D [Phi=all Freq=9.15e+08]
  ff_2D_GainTotal_Stacked: dB(GainTotal) vs Theta on ATK_Solution : FF_Sweep, ATK_2D [Phi=all Freq=all]
  Return Loss: dB(St11) vs Freq on ATK_Solution : SParam_Sweep
  Input Impedance: St11 on ATK_Solution : SParam_Sweep [Freq=all]

# Ansys Electronics Desktop project, version 2024.2
project variables:
  $Substrate_Length = 200mm
  $Substrate_Width = 200mm
  $Substrate_Thickness = 2mm
  $X_Offset = 0mm
  $Coax_Radius = 1.395mm
  $Radius_H = 80mm
  $Patch_Width = 4850mil
  $Height_B = 100mm
  $Coax_Height = -0.5cm
  $Probe_Radius = 0.24mm
materials:
  vacuum: permittivity=1
  FR4_epoxy: permittivity=4.4 dielectric_loss_tangent=0.02
  polyethylene: permittivity=2.25 dielectric_loss_tangent=0.001
  copper: permeability=0.999991 conductivity=58000000
  pec: conductivity=1e+30
  air: permittivity=1.0006 permeability=1.0000004
  PLA_(Added): permittivity=2.54 dielectric_loss_tangent=0.015

design HFSSDesign1 (HFSS, HFSS Terminal Network, model units mm)
geometry:
  Sub1 [PLA_(Added)] = box(corner=(-($Substrate_Length/2), -($Substrate_Width/2), 0mm), size=($Substrate_Length, $Substrate_Width, -$Substrate_Thickness))
  Inf_GND [FR4_epoxy] = object_from(Sub1.face(-z))
  Cutout = circle(normal=Z, centre=($X_Offset, 0mm, -$Substrate_Thickness), radius=$Coax_Radius)
  Inf_GND.subtract(Cutout)
  Curve [PLA_(Added)] = cylinder(axis=Y, base_centre=(0mm, -$Patch_Width/2, -$Radius_H+$Height_B), radius=$Radius_H, height=$Patch_Width)
  Curve.split(plane=XY, keep=PositiveOnly)
  Patch [FR4_epoxy] = object_from(Curve.face(side))
  Box1 [air] = box(corner=(-10cm, -10cm, -$Substrate_Thickness+$Coax_Height), size=(20cm, 20cm, 20cm))
  Coax_Cover [polyethylene] = cylinder(axis=Z, base_centre=($X_Offset, 0mm, -$Substrate_Thickness), radius=$Coax_Radius, height=-5mm)
  Cylinder1 [copper] = cylinder(axis=Z, base_centre=($X_Offset, 0mm, -$Substrate_Thickness), radius=$Probe_Radius, height=-5mm)
  Cylinder2 [copper] = cylinder(axis=Z, base_centre=($X_Offset, 0mm, -$Substrate_Thickness), radius=$Probe_Radius, height=$Height_B+$Substrate_Thickness)
  Cylinder2_1 = Cylinder2.copy()
  Sub1.subtract(Cylinder2_1)
  Cylinder2_2 = Cylinder2.copy()
  Curve.subtract(Cylinder2_2)
boundaries and excitations:
  PerfE2: Perfect E Faces=Patch.face
  Rad1: Radiation Faces=Box1.face(+z, -y, -x, +y, +x)
  PerfE3: Perfect E Objects=Inf_GND InfGroundPlane
  Cylinder1_T1: Terminal port=1 Faces=Cylinder1.face(-z end) TerminalResistance=50ohm
  1: Wave Port Faces=Coax_Cover.face(-z end) WavePortType=Terminal NumModes=1
setups:
  Setup1: HfssDriven Frequency=0.915GHz MaxDeltaS=0.02 MaximumPasses=20 MinimumPasses=1 MinimumConvergedPasses=1 PercentRefinement=30 BasisOrder=1 PortAccuracy=2 DrivenSolverType="Direct Solver" VariableFlagsForDerivatives(1, 1, 1)
    sweep Sweep: 300MHz to 1.5GHz, 401 points; disabled Type=Fast SaveFields
    sweep Sweep_Param: 0.4575GHz to 1.3725GHz, 401 points; disabled Type=Fast SaveFields
    sweep Sweep1: 0.4575GHz to 1.3725GHz, 401 points; Type=Interpolating InterpTolerance=0.5 InterpMaxSolns=250 PassivityErrorTolerance=0.0001
source amplitudes:
  1:1: 1V 0deg
optimetrics:
  ParametricSetup1: Parametric Sim._Setups=[Setup1]
    sweep $Radius_H: LIN 10mm 20mm 1mm
    sweep $Height_B: LIN 0mm 50mm 5mm
radiation setups:
  Infinite Sphere1: Infinite Sphere Theta=0deg..180deg step 2deg Phi=-180deg..180deg step 2deg
reports:
  Terminal S Parameter Plot 1: dB(St(Cylinder1_T1,Cylinder1_T1)) vs Freq on Setup1 : Sweep_Param [$Radius_H=all $Height_B=all]; markers MX1 at x=9.15e+08
  Terminal S Parameter Plot 2: dB(St(Cylinder1_T1,Cylinder1_T1)) vs Freq on Setup1 : Sweep1 [$Radius_H=all $Height_B=all]; markers MX1 at x=9.15e+08
  Terminal S Parameter Plot 3: dB(St(Cylinder1_T1,Cylinder1_T1)) vs Freq on Setup1 : Sweep1 [$Radius_H=all $Height_B=all]; markers MX1 at x=9.15e+08
